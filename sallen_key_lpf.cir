* Sallen-Key 2nd Order Unity-Gain Butterworth Low-Pass Filter
* fc = 1 kHz, Q = 0.7071 (Butterworth)
* Ideal op-amp modeled as high-gain VCVS (voltage follower configuration)

Vin in 0 AC 1 SIN(0 1 1k)

R1 in a 11.3k
R2 a b 11.3k
C1 a out 20n
C2 b 0 10n

* Ideal op-amp: non-inverting input = node b, inverting input = out (unity feedback)
Eopamp out 0 b out 100000

.control
ac dec 200 1 1meg
wrdata bode_data.txt vdb(out) vp(out)
quit
.endc

.end
